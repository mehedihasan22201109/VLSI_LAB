ADE simulation setup
Run mode: Single Run, Sweeps and Corners
Tests:
  Mehedi_NOR_sim_1: Mehedi/NOR_sim/schematic, simulator spectre
    Variables: vdd = 1
